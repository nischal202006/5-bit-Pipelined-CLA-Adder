* SPICE3 file created from XOR.ext - technology: scmos

.option scale=0.09u

M1000 B_bar a_1_196# vdd w_n17_137# pfet w=40 l=2
+  ad=400 pd=180 as=960 ps=368
M1001 a_60_81# a_1_196# A_bar Gnd nfet w=40 l=2
+  ad=240 pd=92 as=200 ps=90
M1002 vdd B_bar Y w_15_57# pfet w=40 l=2
+  ad=0 pd=0 as=400 ps=180
M1003 a_28_1# B_bar Y Gnd nfet w=40 l=2
+  ad=240 pd=92 as=200 ps=90
M1004 a_28_152# B a_1_196# Gnd nfet w=40 l=2
+  ad=240 pd=92 as=200 ps=90
M1005 gnd A_bar a_28_1# Gnd nfet w=40 l=2
+  ad=800 pd=360 as=0 ps=0
M1006 gnd A a_60_81# Gnd nfet w=40 l=2
+  ad=0 pd=0 as=0 ps=0
M1007 Y A_bar vdd w_15_57# pfet w=40 l=2
+  ad=0 pd=0 as=0 ps=0
M1008 a_n4_81# B B_bar Gnd nfet w=40 l=2
+  ad=240 pd=92 as=200 ps=90
M1009 gnd a_1_196# a_n4_81# Gnd nfet w=40 l=2
+  ad=0 pd=0 as=0 ps=0
M1010 gnd A a_28_152# Gnd nfet w=40 l=2
+  ad=0 pd=0 as=0 ps=0
M1011 vdd B a_1_196# w_15_208# pfet w=40 l=2
+  ad=0 pd=0 as=400 ps=180
M1012 vdd a_1_196# A_bar w_47_137# pfet w=40 l=2
+  ad=0 pd=0 as=400 ps=180
M1013 vdd B B_bar w_n17_137# pfet w=40 l=2
+  ad=0 pd=0 as=0 ps=0
M1014 a_1_196# A vdd w_15_208# pfet w=40 l=2
+  ad=0 pd=0 as=0 ps=0
M1015 A_bar A vdd w_47_137# pfet w=40 l=2
+  ad=0 pd=0 as=0 ps=0
C0 w_15_208# a_1_196# 0.13fF
C1 a_1_196# B 0.35fF
C2 w_n17_137# B 0.08fF
C3 a_1_196# B_bar 0.15fF
C4 w_n17_137# B_bar 0.14fF
C5 w_47_137# vdd 0.50fF
C6 a_n4_81# B_bar 0.45fF
C7 A_bar Y 0.08fF
C8 w_15_208# B 0.08fF
C9 A a_1_196# 0.35fF
C10 Y a_28_1# 0.41fF
C11 a_28_152# gnd 0.41fF
C12 A_bar a_1_196# 0.08fF
C13 B B_bar 0.15fF
C14 gnd Y 0.27fF
C15 Y w_15_57# 0.14fF
C16 a_28_152# vdd 0.09fF
C17 Y vdd 0.90fF
C18 w_15_208# A 0.08fF
C19 A B 0.44fF
C20 gnd w_n17_137# 0.03fF
C21 a_1_196# vdd 1.14fF
C22 gnd a_n4_81# 0.41fF
C23 w_n17_137# vdd 0.10fF
C24 A_bar B_bar 0.31fF
C25 a_1_196# w_47_137# 0.08fF
C26 w_15_208# vdd 0.06fF
C27 A_bar A 0.08fF
C28 gnd B_bar 0.12fF
C29 B vdd 0.01fF
C30 w_15_57# B_bar 0.08fF
C31 vdd B_bar 0.90fF
C32 a_28_152# a_1_196# 0.41fF
C33 A vdd 0.33fF
C34 gnd A_bar 0.04fF
C35 A_bar w_15_57# 0.08fF
C36 A_bar a_60_81# 0.41fF
C37 A_bar vdd 1.30fF
C38 gnd a_28_1# 0.41fF
C39 A w_47_137# 0.08fF
C40 a_1_196# w_n17_137# 0.08fF
C41 gnd w_15_57# 0.31fF
C42 A_bar w_47_137# 0.14fF
C43 gnd a_60_81# 0.41fF
C44 gnd vdd 0.10fF
C45 w_15_57# vdd 0.05fF
C46 Y B_bar 0.08fF
C47 a_28_1# Gnd 0.01fF
C48 a_60_81# Gnd 0.01fF
C49 Y Gnd 3.85fF
C50 a_n4_81# Gnd 0.01fF
C51 A_bar Gnd 0.30fF
C52 gnd Gnd 1.91fF
C53 a_28_152# Gnd 0.01fF
C54 B_bar Gnd 0.45fF
C55 vdd Gnd 2.08fF
C56 a_1_196# Gnd 0.42fF
C57 A Gnd 0.85fF
C58 B Gnd 0.85fF
C59 w_15_57# Gnd 1.67fF
C60 w_47_137# Gnd 0.22fF
C61 w_n17_137# Gnd 1.67fF
C62 w_15_208# Gnd 1.67fF
