.include TSMC_180nm.txt
.param LAMBDA=0.09u
.param width_N={20*LAMBDA}
.param width_P = 2.5*width_N
.global gnd vdd
.PARAM VDD_val = 1.8

V_A A gnd PULSE(0 {VDD_val} 2n 100p 100p 32n 64n)
V_B B gnd PULSE(0 {VDD_val} 2n 100p 100p 16n 32n)
V_C C gnd PULSE(0 {VDD_val} 2n 100p 100p 8n 16n)
V_D D gnd PULSE(0 {VDD_val} 2n 100p 100p 4n 8n)
VDD vdd gnd 1.8
*  D G S B

Mp_A_PUN  vdd A Y vdd CMOSP W={width_P}   L={2*LAMBDA}
+ AS={5*width_P*LAMBDA} PS={10*LAMBDA+2*width_P} AD={5*width_P*LAMBDA} PD={10*LAMBDA+2*width_P}

Mp_B_PUN  vdd B Y vdd CMOSP W={width_P}   L={2*LAMBDA}
+ AS={5*width_P*LAMBDA} PS={10*LAMBDA+2*width_P} AD={5*width_P*LAMBDA} PD={10*LAMBDA+2*width_P}

Mp_C_PUN  vdd C Y vdd CMOSP W={width_P}   L={2*LAMBDA}
+ AS={5*width_P*LAMBDA} PS={10*LAMBDA+2*width_P} AD={5*width_P*LAMBDA} PD={10*LAMBDA+2*width_P}

Mp_D_PUN  vdd D Y vdd CMOSP W={width_P}   L={2*LAMBDA}
+ AS={5*width_P*LAMBDA} PS={10*LAMBDA+2*width_P} AD={5*width_P*LAMBDA} PD={10*LAMBDA+2*width_P}

Mn_A_PDN Y A x1 gnd CMOSN  W={4*width_N}   L={2*LAMBDA}
+ AS={5*4*width_N*LAMBDA} PS={10*LAMBDA+2*4*width_N} AD={5*4*width_N*LAMBDA} PD={10*LAMBDA+2*4*width_N}

Mn_B_PDN x1 B x2 gnd CMOSN  W={4*width_N}   L={2*LAMBDA}
+ AS={5*4*width_N*LAMBDA} PS={10*LAMBDA+2*4*width_N} AD={5*4*width_N*LAMBDA} PD={10*LAMBDA+2*4*width_N}

Mn_C_PDN x2 C x3 gnd CMOSN  W={4*width_N}   L={2*LAMBDA}
+ AS={5*4*width_N*LAMBDA} PS={10*LAMBDA+2*4*width_N} AD={5*4*width_N*LAMBDA} PD={10*LAMBDA+2*4*width_N}

Mn_D_PDN x3 D gnd gnd CMOSN  W={4*width_N}   L={2*LAMBDA}
+ AS={5*4*width_N*LAMBDA} PS={10*LAMBDA+2*4*width_N} AD={5*4*width_N*LAMBDA} PD={10*LAMBDA+2*4*width_N}

.tran 10p 50n
.control
set hcopYpscolor = 1 *White background for saving plots
set color0=white ** color0 is used to set the background of the plot (manual sec:17.7))
set color1=black ** color1 is used to set the grid color of the plot (manual sec:17.7))

run
set curplottitle="2024102070 4 input NAND Gate using CMOS"

plot V(A)+8 V(B)+6 V(C)+4 V(D)+2 V(Y)
let half_vdd = 0.9
meas tran t_A_rise WHEN V(A)=half_vdd RISE=1
meas tran t_Y_fall_A WHEN V(Y)=half_vdd FALL=1 TD=2n
let tp_A = t_Y_fall_A - t_A_rise
meas tran t_B_rise WHEN V(B)=half_vdd RISE=1
meas tran t_Y_fall_B WHEN V(Y)=half_vdd FALL=1 TD=5n
let tp_B = t_Y_fall_B - t_B_rise
meas tran t_C_rise WHEN V(C)=half_vdd RISE=1
meas tran t_Y_fall_C WHEN V(Y)=half_vdd FALL=1 TD=7n
let tp_C = t_Y_fall_C - t_C_rise
meas tran t_D_fall WHEN V(D)=half_vdd FALL=1
meas tran t_Y_rise_D WHEN V(Y)=half_vdd RISE=1 TD=8n
let tp_D = t_Y_rise_D - t_D_fall
meas tran tphl trig v(a) val=0.9 rise=1 targ v(y) val=0.9 fall=1
meas tran tplh trig v(d) val=0.9 fall=1 targ v(y) val=0.9 rise=1
let tp_avg = (tphl + tplh) / 2

print tphl tplh tp_avg

.endc
