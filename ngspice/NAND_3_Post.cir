.include TSMC_180nm.txt
.param LAMBDA=0.09u
.param width_N={20*LAMBDA}
.param width_P = 2.5*width_N
.global gnd vdd
.PARAM VDD_val = 1.8

V_A A gnd PULSE(0 {VDD_val} 2n 100p 100p 32n 64n)
V_B B gnd PULSE(0 {VDD_val} 2n 100p 100p 16n 32n)
V_C C gnd PULSE(0 {VDD_val} 2n 100p 100p 8n 16n)
VDD vdd gnd 1.8
*  D G S B
* SPICE3 file created from NAND3.ext - technology: scmos

.option scale=0.09u

M1000 vdd b Y w_9_53# CMOSP w=50 l=2
+  ad=550 pd=222 as=550 ps=222
M1001 a_30_n16# b a_22_n16# Gnd CMOSN w=60 l=2
+  ad=360 pd=132 as=360 ps=132
M1002 Y c vdd w_9_53# CMOSP w=50 l=2
+  ad=0 pd=0 as=0 ps=0
M1003 a_22_n16# a gnd Gnd CMOSN w=60 l=2
+  ad=0 pd=0 as=300 ps=130
M1004 Y a vdd w_9_53# CMOSP w=50 l=2
+  ad=0 pd=0 as=0 ps=0
M1005 Y c a_30_n16# Gnd CMOSN w=60 l=2
+  ad=300 pd=130 as=0 ps=0
C0 c w_9_53# 0.08fF
C1 c Y 0.08fF
C2 b vdd 0.13fF
C3 b w_9_53# 0.08fF
C4 a_30_n16# a_22_n16# 0.62fF
C5 Y a_30_n16# 0.67fF
C6 b Y 0.08fF
C7 a vdd 0.13fF
C8 c b 0.24fF
C9 a w_9_53# 0.08fF
C10 gnd a_22_n16# 0.62fF
C11 gnd Y 0.03fF
C12 w_9_53# vdd 0.12fF
C13 Y vdd 1.60fF
C14 a b 0.24fF
C15 Y w_9_53# 0.10fF
C16 c vdd 0.13fF
C17 Y a_22_n16# 0.05fF
C18 a_30_n16# Gnd 0.01fF
C19 a_22_n16# Gnd 0.01fF
C20 gnd Gnd 0.14fF
C21 Y Gnd 0.19fF
C22 vdd Gnd 0.11fF
C23 c Gnd 0.08fF
C24 b Gnd 0.11fF
C25 a Gnd 0.11fF
C26 w_9_53# Gnd 2.49fF

.tran 10p 50n
.control
set hcopYpscolor = 1 *White background for saving plots
set color0=white ** color0 is used to set the background of the plot (manual sec:17.7))
set color1=black ** color1 is used to set the grid color of the plot (manual sec:17.7))

run
set curplottitle="2024102070 3 input NAND Gate using CMOS Post Layout using Magic"

plot V(A)+6 V(B)+4 V(C)+2 V(Y)
let half_vdd = 0.9
meas tran t_A_rise WHEN V(A)=half_vdd RISE=1
meas tran t_Y_fall_A WHEN V(Y)=half_vdd FALL=1 TD=2n
let tp_A = t_Y_fall_A - t_A_rise

meas tran t_B_rise WHEN V(B)=half_vdd RISE=1
meas tran t_Y_fall_B WHEN V(Y)=half_vdd FALL=1 TD=5n
let tp_B = t_Y_fall_B - t_B_rise

meas tran t_C_fall WHEN V(C)=half_vdd FALL=1
meas tran t_Y_rise_C WHEN V(Y)=half_vdd RISE=1 TD=7n
let tp_C = t_Y_rise_C - t_C_fall

meas tran tphl trig v(a) val=0.9 rise=1 targ v(y) val=0.9 fall=1
meas tran tplh trig v(c) val=0.9 fall=1 targ v(y) val=0.9 rise=1

let tp_avg = (tphl + tplh) / 2

print tphl tplh tp_avg

.endc
